| / 7\'7
| \ \   Xilinx Inc.
| / /
| \_\/.\   IBIS Models for SPARTAN-6
[IBIS ver]   4.2
[File name]   top.ibs
[File Rev]   1.3
[Date]   Wed January 18 20:16:59 2023
[Source]   Derived from spice models, rev0.21, using
   hspice 2007.12
[Notes]   Xilinx IBIS file for SPARTAN-6 I/O standards.
   All models are preliminary.
   The version of IBISCHK used is ibischk4.
   Ibis models were generated using S2IBIS3.
[Disclaimer] The data in this file is derived from SPICE simulations using
                 modeling information extracted from the target process. While
                 a great deal of care has been taken to provide information
                 that is accurate, this model is considered preliminary as it
                 has not been verified by actual silicon measurement. Treat the
                 data in this model as preliminary until actual silicon
                 verification is performed.
[Copyright]   Copyright 2009, 2010, Xilinx Inc., All rights reserved
|   Component SPARTAN-6
[Component]   SPARTAN-6
[Manufacturer]   Xilinx Inc.
[Package]
|FGG484
|variable   typ   min   max
R_pkg   141.41m   48.13m   279.99m
L_pkg   4.96nH   1.77nH   10.53nH
C_pkg   1.34pF   0.74pF   2.70pF
[Pin]  signal_name   model_name
W12   num_out<0>   LVCMOS25_S_12_TB_25
Y12   num_out<1>   LVCMOS25_S_12_TB_25
Y13   num_out<2>   LVCMOS25_S_12_TB_25
AA12   num_out<3>   LVCMOS25_S_12_TB_25
AB12   num_out<4>   LVCMOS25_S_12_TB_25
Y11   num_out<5>   LVCMOS25_S_12_TB_25
AB11   num_out<6>   LVCMOS25_S_12_TB_25
AB10   num_out<7>   LVCMOS25_S_12_TB_25
AB13   Clock   LVCMOS33_S_12_TB_25
A3   HSWAPEN   LVCMOS25_S_8_TB_25
A4   IO_L1N_VREF_0   NC
C5   IO_L2P_0   NC
A5   IO_L2N_0   NC
D6   IO_L3P_0   NC
C6   IO_L3N_0   NC
B6   IO_L4P_0   NC
A6   IO_L4N_0   NC
C7   IO_L5P_0   NC
A7   IO_L5N_0   NC
B8   IO_L6P_0   NC
A8   IO_L6N_0   NC
D9   IO_L7P_0   NC
C8   IO_L7N_0   NC
C9   IO_L8P_0   NC
A9   IO_L8N_VREF_0   NC
D7   IO_L32P_0   NC
D8   IO_L32N_0   NC
D10   IO_L33P_0   NC
C10   IO_L33N_0   NC
B10   GCLK19   NC
A10   GCLK18   NC
C11   GCLK17   NC
A11   GCLK16   NC
D11   GCLK15   NC
C12   GCLK14   NC
B12   GCLK13   NC
A12   GCLK12   NC
C13   IO_L38P_0   NC
A13   IO_L38N_VREF_0   NC
D14   IO_L49P_0   NC
C14   IO_L49N_0   NC
B14   IO_L50P_0   NC
A14   IO_L50N_0   NC
C15   IO_L51P_0   NC
A15   IO_L51N_0   NC
D15   IO_L62P_0   NC
C16   IO_L62N_VREF_0   NC
B16   SCP7   LVCMOS25_S_8_TB_25
A16   SCP6   LVCMOS25_S_8_TB_25
C17   SCP5   LVCMOS25_S_8_TB_25
A17   SCP4   LVCMOS25_S_8_TB_25
B18   SCP3   LVCMOS25_S_8_TB_25
A18   SCP2   LVCMOS25_S_8_TB_25
E16   SCP1   LVCMOS25_S_8_TB_25
D17   SCP0   LVCMOS25_S_8_TB_25
C19   A25   LVCMOS25_S_8_TB_25
B20   A24   LVCMOS25_S_8_TB_25
G16   IO_L9P_1   NC
G17   IO_L9N_1   NC
F16   IO_L10P_1   NC
F17   IO_L10N_1   NC
B21   IO_L19P_1   NC
B22   IO_L19N_1   NC
A20   IO_L20P_1   NC
A21   IO_L20N_1   NC
K16   IO_L21P_1   NC
J16   IO_L21N_1   NC
H16   IO_L28P_1   NC
H17   IO_L28N_VREF_1   NC
D19   A23_M1A13   NC
D20   A22_M1A14   NC
F18   A21_M1RESET   NC
F19   A20_M1A11   NC
D21   A19_M1CKE   NC
D22   A18_M1A12   NC
C20   A17_M1A8   NC
C22   A16_M1A9   NC
G19   A15_M1A10   NC
F20   A14_M1A4   NC
H19   A13_M1WE   NC
H18   A12_M1BA2   NC
E20   A11_M1A7   NC
E22   A10_M1A2   NC
J17   A9_M1BA0   NC
K17   A8_M1BA1   NC
F21   A7_M1A0   NC
F22   A6_M1A1   NC
H20   A5_M1CLK   NC
J19   A4_M1CLKN   NC
G20   M1A3   NC
G22   M1ODT   NC
K20   GCLK11_M1A5   NC
K19   GCLK10_M1A6   NC
H21   GCLK9_IRDY1_M1RASN   NC
H22   GCLK8_M1CASN   NC
M20   GCLK7_M1UDM   NC
L19   GCLK6_TRDY1_M1LDM   NC
J20   GCLK5_M1DQ4   NC
J22   GCLK4_M1DQ5   NC
K21   A3_M1DQ6   NC
K22   A2_M1DQ7   NC
L20   A1_M1LDQS   NC
L22   A0_M1LDQSN   NC
M21   FCS_B_M1DQ2   NC
M22   FOE_B_M1DQ3   NC
N20   FWE_B_M1DQ0   NC
N22   LDC_M1DQ1   NC
P21   HDC_M1DQ8   NC
P22   M1DQ9   NC
R20   M1DQ10   NC
R22   M1DQ11   NC
T21   M1UDQS   NC
T22   M1UDQSN   NC
U20   M1DQ12   NC
U22   M1DQ13   NC
V21   M1DQ14   NC
V22   M1DQ15   NC
M19   IO_L53P_1   NC
N19   IO_L53N_VREF_1   NC
M16   IO_L58P_1   NC
L15   IO_L58N_1   NC
P19   IO_L59P_1   NC
P20   IO_L59N_1   NC
W20   IO_L60P_1   NC
W22   IO_L60N_1   NC
L17   IO_L61P_1   NC
K18   IO_L61N_1   NC
U19   IO_L70P_1   NC
V20   IO_L70N_1   NC
M17   IO_L71P_1   NC
M18   IO_L71N_1   NC
P17   IO_L72P_1   NC
N16   IO_L72N_1   NC
P18   IO_L73P_1   NC
R19   IO_L73N_1   NC
T19   AWAKE   LVCMOS25_S_8_TB_25
T20   DOUT_BUSY   LVCMOS25_S_8_TB_25
Y21   CCLK   LVCMOS25_S_8_TB_25
AA22   M0_CMPMISO   NC
AA21   CMPCLK   NC
AB21   CMPMOSI   NC
AA20   D0_DIN_MISO_MISO1   LVCMOS25_S_8_TB_25
AB20   MOSI_CSI_B_MISO0   LVCMOS25_S_8_TB_25
T18   IO_L4P_2   NC
T17   IO_L4N_VREF_2   NC
Y19   IO_L5P_2   NC
AB19   IO_L5N_2   NC
W18   IO_L6P_2   NC
Y18   IO_L6N_2   NC
T16   IO_L7P_2   NC
T15   IO_L7N_2   NC
U17   IO_L8P_2   NC
U16   IO_L8N_2   NC
V19   IO_L9P_2   NC
V18   IO_L9N_2   NC
R16   IO_L10P_2   NC
R15   IO_L10N_2   NC
V17   IO_L11P_2   NC
W17   IO_L11N_2   NC
U14   D1_MISO2   LVCMOS25_S_8_TB_25
U13   D2_MISO3   LVCMOS25_S_8_TB_25
U15   M1   LVCMOS25_S_8_TB_25
V15   D10   LVCMOS25_S_8_TB_25
AA18   D11   LVCMOS25_S_8_TB_25
AB18   D12   LVCMOS25_S_8_TB_25
Y17   IO_L15P_2   NC
AB17   IO_L15N_2   NC
AA14   IO_L16P_2   NC
AB14   IO_L16N_VREF_2   NC
Y16   IO_L17P_2   NC
W15   IO_L17N_2   NC
V13   IO_L18P_2   NC
W13   IO_L18N_2   NC
AA16   IO_L19P_2   NC
AB16   IO_L19N_2   NC
W14   IO_L20P_2   NC
Y14   IO_L20N_2   NC
Y15   IO_L21P_2   NC
AB15   IO_L21N_2   NC
T12   IO_L22P_2   NC
U12   IO_L22N_2   NC
T14   IO_L23P_2   NC
R13   IO_L23N_2   NC
R11   IO_L40P_2   NC
T11   IO_L40N_2   NC
AA10   IO_L41P_2   NC
V11   IO_L42P_2   NC
W11   IO_L42N_2   NC
Y9   IO_L43P_2   NC
AB9   IO_L43N_2   NC
W10   IO_L44P_2   NC
Y10   IO_L44N_2   NC
AA8   IO_L45P_2   NC
AB8   IO_L45N_2   NC
W8   IO_L46P_2   NC
V7   IO_L46N_2   NC
W9   IO_L47P_2   NC
Y8   IO_L47N_2   NC
Y7   D7   LVCMOS25_S_8_TB_25
AB7   RDWR_B   LVCMOS25_S_8_TB_25
AA6   D3   LVCMOS25_S_8_TB_25
AB6   D4   LVCMOS25_S_8_TB_25
U9   IO_L50P_2   NC
V9   IO_L50N_2   NC
T8   IO_L51P_2   NC
U8   IO_L51N_2   NC
T10   IO_L52P_2   NC
U10   IO_L52N_2   NC
W6   IO_L53P_2   NC
Y6   IO_L53N_2   NC
Y5   IO_L54P_2   NC
AB5   IO_L54N_2   NC
AA4   IO_L57P_2   NC
AB4   IO_L57N_2   NC
Y3   IO_L58P_2   NC
AB3   IO_L58N_2   NC
R9   IO_L59P_2   NC
R8   IO_L59N_2   NC
T7   IO_L60P_2   NC
R7   IO_L60N_2   NC
W4   D5   LVCMOS25_S_8_TB_25
Y4   D6   LVCMOS25_S_8_TB_25
U6   IO_L63P_2   NC
V5   IO_L63N_2   NC
AA2   D8   LVCMOS25_S_8_TB_25
AB2   D9   LVCMOS25_S_8_TB_25
T6   INIT_B   LVCMOS25_S_8_TB_25
T5   CSO_B   LVCMOS25_S_8_TB_25
Y2   IO_L1P_3   NC
Y1   IO_L1N_VREF_3   NC
W3   IO_L2P_3   NC
W1   IO_L2N_3   NC
P8   IO_L7P_3   NC
P7   IO_L7N_3   NC
P6   IO_L8P_3   NC
P5   IO_L8N_3   NC
T4   IO_L9P_3   NC
T3   IO_L9N_3   NC
U4   IO_L10P_3   NC
V3   IO_L10N_3   NC
N6   IO_L11P_3   NC
N7   IO_L11N_3   NC
M7   IO_L23P_3   NC
M8   IO_L23N_3   NC
R4   IO_L24P_3   NC
P4   IO_L24N_3   NC
M6   IO_L25P_3   NC
L6   IO_L25N_3   NC
P3   IO_L26P_3   NC
N4   IO_L26N_3   NC
M5   IO_L31P_3   NC
M4   IO_L31N_VREF_3   NC
V2   M3DQ14   NC
V1   M3DQ15   NC
U3   M3DQ12   NC
U1   M3DQ13   NC
T2   M3UDQS   NC
T1   M3UDQSN   NC
R3   M3DQ10   NC
R1   M3DQ11   NC
P2   M3DQ8   NC
P1   M3DQ9   NC
N3   M3DQ0   NC
N1   M3DQ1   NC
M2   M3DQ2   NC
M1   M3DQ3   NC
L3   M3LDQS   NC
L1   M3LDQSN   NC
K2   M3DQ6   NC
K1   M3DQ7   NC
J3   GCLK27_M3DQ4   NC
J1   GCLK26_M3DQ5   NC
M3   GCLK25_TRDY2_M3UDM   NC
L4   GCLK24_M3LDM   NC
K5   GCLK23_M3RASN   NC
K4   GCLK22_IRDY2_M3CASN  NC
K3   GCLK21_M3A5   NC
J4   GCLK20_M3A6   NC
K6   M3A3   NC
J6   M3ODT   NC
H4   M3CLK   NC
H3   M3CLKN   NC
H2   M3A0   NC
H1   M3A1   NC
G3   M3BA0   NC
G1   M3BA1   NC
H6   M3A7   NC
H5   M3A2   NC
F2   M3WE   NC
F1   M3BA2   NC
G4   M3A10   NC
F3   M3A4   NC
E3   M3A8   NC
E1   M3A9   NC
D2   M3CKE   NC
D1   M3A12   NC
C3   M3RESET   NC
C1   M3A11   NC
G6   M3A13   NC
F5   M3A14   NC
K7   IO_L57P_3   NC
K8   IO_L57N_VREF_3   NC
D5   IO_L58P_3   NC
E4   IO_L58N_3   NC
J7   IO_L59P_3   NC
H8   IO_L59N_3   NC
B2   IO_L60P_3   NC
B1   IO_L60N_3   NC
G7   IO_L80P_3   NC
F7   IO_L80N_3   NC
D3   IO_L81P_3   NC
C4   IO_L81N_3   NC
E5   IO_L82P_3   NC
E6   IO_L82N_3   NC
A2   IO_L83P_3   NC
B3   IO_L83N_VREF_3   NC
G15   TCK   LVCMOS25_S_8_TB_25
E18   TDI   LVCMOS25_S_8_TB_25
C18   TMS   LVCMOS25_S_8_TB_25
A19   TDO   LVCMOS25_S_8_TB_25
N15   SUSPEND   LVCMOS25_S_8_TB_25
Y20   CMPCS_B_2   NC
Y22   DONE_2   LVCMOS25_S_8_TB_25
AA1   PROGRAM_B_2   LVCMOS25_S_8_TB_25
A1   GND   GND
A22   GND   GND
AA13   GND   GND
AA17   GND   GND
AA5   GND   GND
AA9   GND   GND
AB1   GND   GND
AB22   GND   GND
B13   GND   GND
B17   GND   GND
B5   GND   GND
B9   GND   GND
D18   GND   GND
D4   GND   GND
E11   GND   GND
E15   GND   GND
E2   GND   GND
E21   GND   GND
E7   GND   GND
G18   GND   GND
G5   GND   GND
H7   GND   GND
J11   GND   GND
J13   GND   GND
J15   GND   GND
J2   GND   GND
J21   GND   GND
J9   GND   GND
K10   GND   GND
K12   GND   GND
K14   GND   GND
L11   GND   GND
L13   GND   GND
L18   GND   GND
L5   GND   GND
L9   GND   GND
M10   GND   GND
M12   GND   GND
M14   GND   GND
N11   GND   GND
N13   GND   GND
N17   GND   GND
N2   GND   GND
N21   GND   GND
N9   GND   GND
P10   GND   GND
P12   GND   GND
P14   GND   GND
R18   GND   GND
R5   GND   GND
U2   GND   GND
U21   GND   GND
U7   GND   GND
V10   GND   GND
V14   GND   GND
V4   GND   GND
W16   GND   GND
W19   GND   GND
W7   GND   GND
B11   VCCO_0   POWER
B15   VCCO_0   POWER
B19   VCCO_0   POWER
B4   VCCO_0   POWER
B7   VCCO_0   POWER
E13   VCCO_0   POWER
E17   VCCO_0   POWER
E9   VCCO_0   POWER
G10   VCCO_0   POWER
G14   VCCO_0   POWER
D16   VCCAUX   POWER
F11   VCCAUX   POWER
G12   VCCAUX   POWER
H15   VCCAUX   POWER
H9   VCCAUX   POWER
K15   VCCAUX   POWER
L8   VCCAUX   POWER
M15   VCCAUX   POWER
N8   VCCAUX   POWER
R10   VCCAUX   POWER
R12   VCCAUX   POWER
R6   VCCAUX   POWER
U11   VCCAUX   POWER
V6   VCCAUX   POWER
J10   VCCINT   POWER
J12   VCCINT   POWER
J14   VCCINT   POWER
J8   VCCINT   POWER
K11   VCCINT   POWER
K13   VCCINT   POWER
K9   VCCINT   POWER
L10   VCCINT   POWER
L12   VCCINT   POWER
L14   VCCINT   POWER
M11   VCCINT   POWER
M13   VCCINT   POWER
M9   VCCINT   POWER
N10   VCCINT   POWER
N12   VCCINT   POWER
N14   VCCINT   POWER
P11   VCCINT   POWER
P13   VCCINT   POWER
P9   VCCINT   POWER
R14   VCCINT   POWER
C21   VCCO_1   POWER
E19   VCCO_1   POWER
G21   VCCO_1   POWER
J18   VCCO_1   POWER
L16   VCCO_1   POWER
L21   VCCO_1   POWER
N18   VCCO_1   POWER
R21   VCCO_1   POWER
U18   VCCO_1   POWER
W21   VCCO_1   POWER
AA11   VCCO_2   POWER
AA15   VCCO_2   POWER
AA19   VCCO_2   POWER
AA3   VCCO_2   POWER
AA7   VCCO_2   POWER
T13   VCCO_2   POWER
T9   VCCO_2   POWER
V12   VCCO_2   POWER
V16   VCCO_2   POWER
V8   VCCO_2   POWER
W5   VCCO_2   POWER
C2   VCCO_3   POWER
F4   VCCO_3   POWER
F6   VCCO_3   POWER
G2   VCCO_3   POWER
J5   VCCO_3   POWER
L2   VCCO_3   POWER
L7   VCCO_3   POWER
N5   VCCO_3   POWER
R2   VCCO_3   POWER
U5   VCCO_3   POWER
W2   VCCO_3   POWER
[Package Model]   fgg484_xc6slx45
[Diff Pin]   inv_Pin   vdiff   tdelay_typ   tdelay_min   tdelay_max
[Series Pin Mapping] pin_2   model_name   function_table_group
[Define Package Model]   fgg484_xc6slx45
[Manufacturer]   Xilinx Inc.
[OEM]   Xilinx_S1
[Description]   330-pin Package
|[Number of Sections]   1
[Number of Pins]   330
[Pin Numbers]
|[Pin Name]  Net Number   Net Name   Net's All Pins
D16   | 1   VCCAUX   D16
   |F11
   |G12
   |H15
   |H9
   |K15
   |L8
   |M15
   |N8
   |R10
   |R12
   |R6
   |U11
   |V6
J10   | 2   VCCINT   J10
   |J12
   |J14
   |J8
   |K11
   |K13
   |K9
   |L10
   |L12
   |L14
   |M11
   |M13
   |M9
   |N10
   |N12
   |N14
   |P11
   |P13
   |P9
   |R14
B11   | 3   VCCO_0   B11
   |B15
   |B19
   |B4
   |B7
   |E13
   |E17
   |E9
   |G10
   |G14
C21   | 4   VCCO_1   C21
   |E19
   |G21
   |J18
   |L16
   |L21
   |N18
   |R21
   |U18
   |W21
AA11   | 5   VCCO_2   AA11
   |AA15
   |AA19
   |AA3
   |AA7
   |T13
   |T9
   |V12
   |V16
   |V8
   |W5
C2   | 6   VCCO_3   C2
   |F4
   |F6
   |G2
   |J5
   |L2
   |L7
   |N5
   |R2
   |U5
   |W2
Y20   | 7   CMPCS_B_2   Y20
Y22   | 8   DONE_2   Y22
F17   | 9   IO_L10N_1   F17
R15   | 10   IO_L10N_2   R15
V3   | 11   IO_L10N_3   V3
F16   | 12   IO_L10P_1   F16
R16   | 13   IO_L10P_2   R16
U4   | 14   IO_L10P_3   U4
W17   | 15   IO_L11N_2   W17
N7   | 16   IO_L11N_3   N7
V17   | 17   IO_L11P_2   V17
N6   | 18   IO_L11P_3   N6
U13   | 19   IO_L12N_D2_MISO3_2   U13
U14   | 20   IO_L12P_D1_MISO2_2   U14
V15   | 21   IO_L13N_D10_2   V15
U15   | 22   IO_L13P_M1_2   U15
AB18   | 23   IO_L14N_D12_2   AB18
AA18   | 24   IO_L14P_D11_2   AA18
AB17   | 25   IO_L15N_2   AB17
Y17   | 26   IO_L15P_2   Y17
AB14   | 27   IO_L16N_VREF_2   AB14
AA14   | 28   IO_L16P_2   AA14
W15   | 29   IO_L17N_2   W15
Y16   | 30   IO_L17P_2   Y16
W13   | 31   IO_L18N_2   W13
V13   | 32   IO_L18P_2   V13
B22   | 33   IO_L19N_1   B22
AB16   | 34   IO_L19N_2   AB16
B21   | 35   IO_L19P_1   B21
AA16   | 36   IO_L19P_2   AA16
B20   | 37   IO_L1N_A24_VREF_1   B20
A4   | 38   IO_L1N_IREF_VREF_0   A4
AA22   | 39   IO_L1N_M0_CMPMISO_2   AA22
Y1   | 40   IO_L1N_VREF_3   Y1
C19   | 41   IO_L1P_A25_1   C19
Y21   | 42   IO_L1P_CCLK_2   Y21
A3   | 43   IO_L1P_HSWAPEN_0   A3
Y2   | 44   IO_L1P_VBG_3   Y2
A21   | 45   IO_L20N_1   A21
Y14   | 46   IO_L20N_2   Y14
A20   | 47   IO_L20P_1   A20
W14   | 48   IO_L20P_2   W14
J16   | 49   IO_L21N_1   J16
AB15   | 50   IO_L21N_2   AB15
K16   | 51   IO_L21P_1   K16
Y15   | 52   IO_L21P_2   Y15
U12   | 53   IO_L22N_2   U12
T12   | 54   IO_L22P_2   T12
R13   | 55   IO_L23N_2   R13
M8   | 56   IO_L23N_3   M8
T14   | 57   IO_L23P_2   T14
M7   | 58   IO_L23P_3   M7
P4   | 59   IO_L24N_3   P4
R4   | 60   IO_L24P_3   R4
L6   | 61   IO_L25N_3   L6
M6   | 62   IO_L25P_3   M6
N4   | 63   IO_L26N_3   N4
P3   | 64   IO_L26P_3   P3
H17   | 65   IO_L28N_VREF_1   H17
H16   | 66   IO_L28P_1   H16
D20   | 67   IO_L29N_A22_M1A14_1   D20
Y12   | 68   IO_L29N_GCLK2_2   Y12
D19   | 69   IO_L29P_A23_M1A13_1   D19
W12   | 70   IO_L29P_GCLK3_2   W12
A5   | 71   IO_L2N_0   A5
AB21   | 72   IO_L2N_CMPMOSI_2   AB21
W1   | 73   IO_L2N_VTEMP_3   W1
C5   | 74   IO_L2P_0   C5
AA21   | 75   IO_L2P_CMPCLK_2   AA21
W3   | 76   IO_L2P_VGG_3   W3
F19   | 77   IO_L30N_A20_M1A11_1   F19
AB13   | 78   IO_L30N_GCLK0_USERCCLK_2   AB13
F18   | 79   IO_L30P_A21_M1RESET_1   F18
Y13   | 80   IO_L30P_GCLK1_D13_2   Y13
D22   | 81   IO_L31N_A18_M1A12_1   D22
AB12   | 82   IO_L31N_GCLK30_D15_2   AB12
M4   | 83   IO_L31N_VREF_3   M4
M5   | 84   IO_L31P_3   M5
D21   | 85   IO_L31P_A19_M1CKE_1   D21
AA12   | 86   IO_L31P_GCLK31_D14_2   AA12
D8   | 87   IO_L32N_0   D8
C22   | 88   IO_L32N_A16_M1A9_1   C22
AB11   | 89   IO_L32N_GCLK28_2   AB11
V1   | 90   IO_L32N_M3DQ15_3   V1
D7   | 91   IO_L32P_0   D7
C20   | 92   IO_L32P_A17_M1A8_1   C20
Y11   | 93   IO_L32P_GCLK29_2   Y11
V2   | 94   IO_L32P_M3DQ14_3   V2
C10   | 95   IO_L33N_0   C10
F20   | 96   IO_L33N_A14_M1A4_1   F20
U1   | 97   IO_L33N_M3DQ13_3   U1
D10   | 98   IO_L33P_0   D10
G19   | 99   IO_L33P_A15_M1A10_1   G19
U3   | 100   IO_L33P_M3DQ12_3   U3
H18   | 101   IO_L34N_A12_M1BA2_1   H18
A10   | 102   IO_L34N_GCLK18_0   A10
T1   | 103   IO_L34N_M3UDQSN_3   T1
H19   | 104   IO_L34P_A13_M1WE_1   H19
B10   | 105   IO_L34P_GCLK19_0   B10
T2   | 106   IO_L34P_M3UDQS_3   T2
E22   | 107   IO_L35N_A10_M1A2_1   E22
A11   | 108   IO_L35N_GCLK16_0   A11
R1   | 109   IO_L35N_M3DQ11_3   R1
E20   | 110   IO_L35P_A11_M1A7_1   E20
C11   | 111   IO_L35P_GCLK17_0   C11
R3   | 112   IO_L35P_M3DQ10_3   R3
K17   | 113   IO_L36N_A8_M1BA1_1   K17
C12   | 114   IO_L36N_GCLK14_0   C12
P1   | 115   IO_L36N_M3DQ9_3   P1
J17   | 116   IO_L36P_A9_M1BA0_1   J17
D11   | 117   IO_L36P_GCLK15_0   D11
P2   | 118   IO_L36P_M3DQ8_3   P2
F22   | 119   IO_L37N_A6_M1A1_1   F22
A12   | 120   IO_L37N_GCLK12_0   A12
N1   | 121   IO_L37N_M3DQ1_3   N1
F21   | 122   IO_L37P_A7_M1A0_1   F21
B12   | 123   IO_L37P_GCLK13_0   B12
N3   | 124   IO_L37P_M3DQ0_3   N3
J19   | 125   IO_L38N_A4_M1CLKN_1   J19
M1   | 126   IO_L38N_M3DQ3_3   M1
A13   | 127   IO_L38N_VREF_0   A13
C13   | 128   IO_L38P_0   C13
H20   | 129   IO_L38P_A5_M1CLK_1   H20
M2   | 130   IO_L38P_M3DQ2_3   M2
G22   | 131   IO_L39N_M1ODT_1   G22
L1   | 132   IO_L39N_M3LDQSN_3   L1
G20   | 133   IO_L39P_M1A3_1   G20
L3   | 134   IO_L39P_M3LDQS_3   L3
C6   | 135   IO_L3N_0   C6
AB20   | 136   IO_L3N_MOSI_CSI_B_MISO0_2   AB20
D6   | 137   IO_L3P_0   D6
AA20   | 138   IO_L3P_D0_DIN_MISO_MISO1_2   AA20
T11   | 139   IO_L40N_2   T11
K19   | 140   IO_L40N_GCLK10_M1A6_1   K19
K1   | 141   IO_L40N_M3DQ7_3   K1
R11   | 142   IO_L40P_2   R11
K20   | 143   IO_L40P_GCLK11_M1A5_1   K20
K2   | 144   IO_L40P_M3DQ6_3   K2
J1   | 145   IO_L41N_GCLK26_M3DQ5_3   J1
H22   | 146   IO_L41N_GCLK8_M1CASN_1   H22
AB10   | 147   IO_L41N_VREF_2   AB10
AA10   | 148   IO_L41P_2   AA10
J3   | 149   IO_L41P_GCLK27_M3DQ4_3   J3
H21   | 150   IO_L41P_GCLK9_IRDY1_M1RASN_1   H21
W11   | 151   IO_L42N_2   W11
L4   | 152   IO_L42N_GCLK24_M3LDM_3   L4
L19   | 153   IO_L42N_GCLK6_TRDY1_M1LDM_1   L19
V11   | 154   IO_L42P_2   V11
M3   | 155   IO_L42P_GCLK25_TRDY2_M3UDM_3   M3
M20   | 156   IO_L42P_GCLK7_M1UDM_1   M20
AB9   | 157   IO_L43N_2   AB9
K4   | 158   IO_L43N_GCLK22_IRDY2_M3CASN_3   K4
J22   | 159   IO_L43N_GCLK4_M1DQ5_1   J22
Y9   | 160   IO_L43P_2   Y9
K5   | 161   IO_L43P_GCLK23_M3RASN_3   K5
J20   | 162   IO_L43P_GCLK5_M1DQ4_1   J20
Y10   | 163   IO_L44N_2   Y10
K22   | 164   IO_L44N_A2_M1DQ7_1   K22
J4   | 165   IO_L44N_GCLK20_M3A6_3   J4
W10   | 166   IO_L44P_2   W10
K21   | 167   IO_L44P_A3_M1DQ6_1   K21
K3   | 168   IO_L44P_GCLK21_M3A5_3   K3
AB8   | 169   IO_L45N_2   AB8
L22   | 170   IO_L45N_A0_M1LDQSN_1   L22
J6   | 171   IO_L45N_M3ODT_3   J6
AA8   | 172   IO_L45P_2   AA8
L20   | 173   IO_L45P_A1_M1LDQS_1   L20
K6   | 174   IO_L45P_M3A3_3   K6
V7   | 175   IO_L46N_2   V7
M22   | 176   IO_L46N_FOE_B_M1DQ3_1   M22
H3   | 177   IO_L46N_M3CLKN_3   H3
W8   | 178   IO_L46P_2   W8
M21   | 179   IO_L46P_FCS_B_M1DQ2_1   M21
H4   | 180   IO_L46P_M3CLK_3   H4
Y8   | 181   IO_L47N_2   Y8
N22   | 182   IO_L47N_LDC_M1DQ1_1   N22
H1   | 183   IO_L47N_M3A1_3   H1
W9   | 184   IO_L47P_2   W9
N20   | 185   IO_L47P_FWE_B_M1DQ0_1   N20
H2   | 186   IO_L47P_M3A0_3   H2
P22   | 187   IO_L48N_M1DQ9_1   P22
G1   | 188   IO_L48N_M3BA1_3   G1
AB7   | 189   IO_L48N_RDWR_B_VREF_2   AB7
Y7   | 190   IO_L48P_D7_2   Y7
P21   | 191   IO_L48P_HDC_M1DQ8_1   P21
G3   | 192   IO_L48P_M3BA0_3   G3
C14   | 193   IO_L49N_0   C14
AB6   | 194   IO_L49N_D4_2   AB6
R22   | 195   IO_L49N_M1DQ11_1   R22
H5   | 196   IO_L49N_M3A2_3   H5
D14   | 197   IO_L49P_0   D14
AA6   | 198   IO_L49P_D3_2   AA6
R20   | 199   IO_L49P_M1DQ10_1   R20
H6   | 200   IO_L49P_M3A7_3   H6
A6   | 201   IO_L4N_0   A6
T17   | 202   IO_L4N_VREF_2   T17
B6   | 203   IO_L4P_0   B6
T18   | 204   IO_L4P_2   T18
A14   | 205   IO_L50N_0   A14
V9   | 206   IO_L50N_2   V9
T22   | 207   IO_L50N_M1UDQSN_1   T22
F1   | 208   IO_L50N_M3BA2_3   F1
B14   | 209   IO_L50P_0   B14
U9   | 210   IO_L50P_2   U9
T21   | 211   IO_L50P_M1UDQS_1   T21
F2   | 212   IO_L50P_M3WE_3   F2
A15   | 213   IO_L51N_0   A15
U8   | 214   IO_L51N_2   U8
U22   | 215   IO_L51N_M1DQ13_1   U22
F3   | 216   IO_L51N_M3A4_3   F3
C15   | 217   IO_L51P_0   C15
T8   | 218   IO_L51P_2   T8
U20   | 219   IO_L51P_M1DQ12_1   U20
G4   | 220   IO_L51P_M3A10_3   G4
U10   | 221   IO_L52N_2   U10
V22   | 222   IO_L52N_M1DQ15_1   V22
E1   | 223   IO_L52N_M3A9_3   E1
T10   | 224   IO_L52P_2   T10
V21   | 225   IO_L52P_M1DQ14_1   V21
E3   | 226   IO_L52P_M3A8_3   E3
Y6   | 227   IO_L53N_2   Y6
D1   | 228   IO_L53N_M3A12_3   D1
N19   | 229   IO_L53N_VREF_1   N19
M19   | 230   IO_L53P_1   M19
W6   | 231   IO_L53P_2   W6
D2   | 232   IO_L53P_M3CKE_3   D2
AB5   | 233   IO_L54N_2   AB5
C1   | 234   IO_L54N_M3A11_3   C1
Y5   | 235   IO_L54P_2   Y5
C3   | 236   IO_L54P_M3RESET_3   C3
F5   | 237   IO_L55N_M3A14_3   F5
G6   | 238   IO_L55P_M3A13_3   G6
AB4   | 239   IO_L57N_2   AB4
K8   | 240   IO_L57N_VREF_3   K8
AA4   | 241   IO_L57P_2   AA4
K7   | 242   IO_L57P_3   K7
L15   | 243   IO_L58N_1   L15
AB3   | 244   IO_L58N_2   AB3
E4   | 245   IO_L58N_3   E4
M16   | 246   IO_L58P_1   M16
Y3   | 247   IO_L58P_2   Y3
D5   | 248   IO_L58P_3   D5
P20   | 249   IO_L59N_1   P20
R8   | 250   IO_L59N_2   R8
H8   | 251   IO_L59N_3   H8
P19   | 252   IO_L59P_1   P19
R9   | 253   IO_L59P_2   R9
J7   | 254   IO_L59P_3   J7
A7   | 255   IO_L5N_0   A7
AB19   | 256   IO_L5N_2   AB19
C7   | 257   IO_L5P_0   C7
Y19   | 258   IO_L5P_2   Y19
W22   | 259   IO_L60N_1   W22
R7   | 260   IO_L60N_2   R7
B1   | 261   IO_L60N_3   B1
W20   | 262   IO_L60P_1   W20
T7   | 263   IO_L60P_2   T7
B2   | 264   IO_L60P_3   B2
K18   | 265   IO_L61N_1   K18
L17   | 266   IO_L61P_1   L17
Y4   | 267   IO_L62N_D6_2   Y4
C16   | 268   IO_L62N_VREF_0   C16
D15   | 269   IO_L62P_0   D15
W4   | 270   IO_L62P_D5_2   W4
V5   | 271   IO_L63N_2   V5
A16   | 272   IO_L63N_SCP6_0   A16
U6   | 273   IO_L63P_2   U6
B16   | 274   IO_L63P_SCP7_0   B16
AB2   | 275   IO_L64N_D9_2   AB2
A17   | 276   IO_L64N_SCP4_0   A17
AA2   | 277   IO_L64P_D8_2   AA2
C17   | 278   IO_L64P_SCP5_0   C17
T5   | 279   IO_L65N_CSO_B_2   T5
A18   | 280   IO_L65N_SCP2_0   A18
T6   | 281   IO_L65P_INIT_B_2   T6
B18   | 282   IO_L65P_SCP3_0   B18
D17   | 283   IO_L66N_SCP0_0   D17
E16   | 284   IO_L66P_SCP1_0   E16
A8   | 285   IO_L6N_0   A8
Y18   | 286   IO_L6N_2   Y18
B8   | 287   IO_L6P_0   B8
W18   | 288   IO_L6P_2   W18
V20   | 289   IO_L70N_1   V20
U19   | 290   IO_L70P_1   U19
M18   | 291   IO_L71N_1   M18
M17   | 292   IO_L71P_1   M17
N16   | 293   IO_L72N_1   N16
P17   | 294   IO_L72P_1   P17
R19   | 295   IO_L73N_1   R19
P18   | 296   IO_L73P_1   P18
T20   | 297   IO_L74N_DOUT_BUSY_1   T20
T19   | 298   IO_L74P_AWAKE_1   T19
C8   | 299   IO_L7N_0   C8
T15   | 300   IO_L7N_2   T15
P7   | 301   IO_L7N_3   P7
D9   | 302   IO_L7P_0   D9
T16   | 303   IO_L7P_2   T16
P8   | 304   IO_L7P_3   P8
F7   | 305   IO_L80N_3   F7
G7   | 306   IO_L80P_3   G7
C4   | 307   IO_L81N_3   C4
D3   | 308   IO_L81P_3   D3
E6   | 309   IO_L82N_3   E6
E5   | 310   IO_L82P_3   E5
B3   | 311   IO_L83N_VREF_3   B3
A2   | 312   IO_L83P_3   A2
U16   | 313   IO_L8N_2   U16
P5   | 314   IO_L8N_3   P5
A9   | 315   IO_L8N_VREF_0   A9
C9   | 316   IO_L8P_0   C9
U17   | 317   IO_L8P_2   U17
P6   | 318   IO_L8P_3   P6
G17   | 319   IO_L9N_1   G17
V18   | 320   IO_L9N_2   V18
T3   | 321   IO_L9N_3   T3
G16   | 322   IO_L9P_1   G16
V19   | 323   IO_L9P_2   V19
T4   | 324   IO_L9P_3   T4
AA1   | 325   PROGRAM_B_2   AA1
N15   | 326   SUSPEND   N15
G15   | 327   TCK   G15
E18   | 328   TDI   E18
A19   | 329   TDO   A19
C18   | 330   TMS   C18
[Model Data]
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[End Model Data]
[End Package Model]
| Models and submodels in the file (3): LVCMOS25_S_8_TB_25 (I/O), LVCMOS25_S_12_TB_25 (I/O), LVCMOS33_S_12_TB_25 (I/O)
